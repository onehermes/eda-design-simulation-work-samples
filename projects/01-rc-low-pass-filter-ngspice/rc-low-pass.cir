* RC low-pass filter example for ngspice
* Node names:
* in  = input source node
* out = filter output node
* 0   = ground reference

V1 in 0 AC 1
R1 in out 1k
C1 out 0 100n

.ac dec 100 10 100k

.control
run
plot vdb(out) vp(out)
print v(out)
.endc

.end
